//////////////////////////////////////////////////////////////////////////////
// Copyright 2026 IHP-Open-PDK Authors
//
// Licensed under the Apache License, Version 2.0 (the "License");
// you may not use this file except in compliance with the License.
// You may obtain a copy of the License at
//
//     https://www.apache.org/licenses/LICENSE-2.0
//
// Unless required by applicable law or agreed to in writing, software
// distributed under the License is distributed on an "AS IS" BASIS,
// WITHOUT WARRANTIES OR CONDITIONS OF ANY KIND, either express or implied.
// See the License for the specific language governing permissions and
// limitations under the License.
//////////////////////////////////////////////////////////////////////////////
`include "disciplines.vams"

// D flip flop.
module dff (q, d, clk);
   parameter integer dir = +1 from [-1:+1] exclude 0;
             // if dir=+1, rising clock edge triggers flip flop
             // if dir=-1, falling clock edge triggers flip flop
   output q;                         // Q output
   input clk;                        // Clock input (edge triggered)
   input d;                          // D input
   electrical q, clk, d;
   integer state;
   analog begin
       @(cross(V(clk) - 0.5, dir))
           state = (V(d) > 0.5);
       V(q) <+ transition(state ? 1 : 0, 0, 0);
   end
endmodule
