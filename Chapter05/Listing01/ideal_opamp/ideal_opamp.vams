//////////////////////////////////////////////////////////////////////////////
// Copyright 2026 IHP-Open-PDK Authors
//
// Licensed under the Apache License, Version 2.0 (the "License");
// you may not use this file except in compliance with the License.
// You may obtain a copy of the License at
//
//     https://www.apache.org/licenses/LICENSE-2.0
//
// Unless required by applicable law or agreed to in writing, software
// distributed under the License is distributed on an "AS IS" BASIS,
// WITHOUT WARRANTIES OR CONDITIONS OF ANY KIND, either express or implied.
// See the License for the specific language governing permissions and
// limitations under the License.
//////////////////////////////////////////////////////////////////////////////

`include "disciplines.vams"

// Ideal opamp from The Designer's Guide, Chapter 5, Listing 1.
// Gnucap/modelgen supports indirect contributions, so the original
// behavioral equation is preserved.
module ideal_opamp (pout, nout, pin, nin);
   output pout, nout;
   input pin, nin;
   electrical pin, nin, pout, nout;
   branch (pout, nout) out;
   branch (pin, nin) in;
   analog begin
      V(out): V(in) == 0;
   end
endmodule
