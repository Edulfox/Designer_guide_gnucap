//////////////////////////////////////////////////////////////////////////////
// Copyright 2026 IHP-Open-PDK Authors
//
// Licensed under the Apache License, Version 2.0 (the "License");
// you may not use this file except in compliance with the License.
// You may obtain a copy of the License at
//
//     https://www.apache.org/licenses/LICENSE-2.0
//
// Unless required by applicable law or agreed to in writing, software
// distributed under the License is distributed on an "AS IS" BASIS,
// WITHOUT WARRANTIES OR CONDITIONS OF ANY KIND, either express or implied.
// See the License for the specific language governing permissions and
// limitations under the License.
//////////////////////////////////////////////////////////////////////////////

`include "disciplines.vams"

// Comparator from The Designer's Guide, Chapter 5, Listing 5.
module comparator (out, pin, nin);
   parameter real td = 1n;
   parameter real tt = 1n;
   output out;
   input pin, nin;
   electrical out, pin, nin;
   real Vout;
   analog begin
      @(cross(V(pin) - V(nin), 0))
         ;
      Vout = (V(pin) > V(nin)) ? 1.0 : 0.0;
      V(out) <+ transition(Vout, td, tt);
   end
endmodule
