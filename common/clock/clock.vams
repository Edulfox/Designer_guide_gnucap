//////////////////////////////////////////////////////////////////////////////
// Copyright 2026 IHP-Open-PDK Authors
//
// Licensed under the Apache License, Version 2.0 (the "License");
// you may not use this file except in compliance with the License.
// You may obtain a copy of the License at
//
//     https://www.apache.org/licenses/LICENSE-2.0
//
// Unless required by applicable law or agreed to in writing, software
// distributed under the License is distributed on an "AS IS" BASIS,
// WITHOUT WARRANTIES OR CONDITIONS OF ANY KIND, either express or implied.
// See the License for the specific language governing permissions and
// limitations under the License.
//////////////////////////////////////////////////////////////////////////////

`include "disciplines.vams"

module clock(clk, en);
   output clk;
   input en;
   reg clk;
   logic en, clk;
   parameter real frecuency = 10000M;
   parameter real cycle = 1/frecuency;
   parameter real delay = cycle/2;
   parameter real duty = 50.0;
   parameter real step = duty*cycle/100.0;

   initial begin
      en = 1;
      clk = 0;
   end

   always @(timer(delay, cycle)) begin
      if (en) clk = !clk;
      else clk = 0;
   end
   always @(timer(delay+step, cycle)) begin
      if (en) clk = !clk;
      else clk = 0;
   end
endmodule
