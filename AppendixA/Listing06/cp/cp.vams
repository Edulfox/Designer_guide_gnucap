//////////////////////////////////////////////////////////////////////////////
// Copyright 2026 IHP-Open-PDK Authors
//
// Licensed under the Apache License, Version 2.0 (the "License");
// you may not use this file except in compliance with the License.
// You may obtain a copy of the License at
//
//     https://www.apache.org/licenses/LICENSE-2.0
//
// Unless required by applicable law or agreed to in writing, software
// distributed under the License is distributed on an "AS IS" BASIS,
// WITHOUT WARRANTIES OR CONDITIONS OF ANY KIND, either express or implied.
// See the License for the specific language governing permissions and
// limitations under the License.
//////////////////////////////////////////////////////////////////////////////
`include "disciplines.vams"

// Charge pump from Designer's Guide, Appendix A, Listing 6.
// `timescale is omitted; digital timing is supplied by the testbench logic model.
module cp (pout, nout, inc, dec);
   parameter real cur = 1m;
   input inc, dec;
   logic inc, dec;
   electrical pout, nout;
   real out;

   analog begin
       @(initial_step) out = 0.0;
       if (dec && !inc)
           out = -cur;
       else if (!dec && inc)
           out = cur;
       else
           out = 0;
       I(pout, nout) <+ -transition(out, 0.0, 10n, 10n);
   end
endmodule
