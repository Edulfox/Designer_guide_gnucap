//////////////////////////////////////////////////////////////////////////////
// Copyright 2026 IHP-Open-PDK Authors
//
// Licensed under the Apache License, Version 2.0 (the "License");
// you may not use this file except in compliance with the License.
// You may obtain a copy of the License at
//
//     https://www.apache.org/licenses/LICENSE-2.0
//
// Unless required by applicable law or agreed to in writing, software
// distributed under the License is distributed on an "AS IS" BASIS,
// WITHOUT WARRANTIES OR CONDITIONS OF ANY KIND, either express or implied.
// See the License for the specific language governing permissions and
// limitations under the License.
//////////////////////////////////////////////////////////////////////////////

`include "disciplines.vams"

// Frequency divider from Designer's Guide, Appendix A, Listing 7.
// Gnucap compatibility notes:
// - The timescale directive is omitted; timing is defined by the testbench logic model.
// - Scalar logical negation is used because it is exercised by modelgen regressions.
// - The book's internal register q is folded into the output register. Internal
//   procedural logic registers are not code-generated by this snapshot, while
//   procedural assignment to an output reg is regression-tested.
module fd (out, clk, reset);
   input clk, reset;
   output out;
   reg out;
   logic out, clk, reset;
   integer i = 0;

   // The book initializes q on the falling edge of reset.
   always @(negedge(reset)) begin
       i = 0;
       out = 0;
   end

   // In the book, assign out = q & !reset forces the observable output low
   // whenever reset is high. Preserve that externally visible behavior.
   always @(posedge(reset)) begin
       out = 0;
   end

   always @(posedge(clk)) begin
       if (!reset) begin
           i = i + 1;
           if (i == 63) begin
               out = !out;
               i = 0;
           end
       end
   end
endmodule
