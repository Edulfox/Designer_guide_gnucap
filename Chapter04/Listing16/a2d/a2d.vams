//////////////////////////////////////////////////////////////////////////////
// Copyright 2026 IHP-Open-PDK Authors
//
// Licensed under the Apache License, Version 2.0 (the "License");
// you may not use this file except in compliance with the License.
// You may obtain a copy of the License at
//
//     https://www.apache.org/licenses/LICENSE-2.0
//
// Unless required by applicable law or agreed to in writing, software
// distributed under the License is distributed on an "AS IS" BASIS,
// WITHOUT WARRANTIES OR CONDITIONS OF ANY KIND, either express or implied.
// See the License for the specific language governing permissions and
// limitations under the License.
//////////////////////////////////////////////////////////////////////////////

`include "disciplines.vams"

// Basic electrical-to-logic converter based on Designer's Guide Listing 16.
// The original connectmodule is represented as a regular mixed-signal module
// because the current Gnucap model generator does not emit standalone
// prototypes for connectmodule declarations.
module a2d (out, in);

   parameter real vh = 2.7;
   parameter real vl = 0.5;
   parameter real c = 100f;

   input in;
   output out;

   electrical in;

   reg out;
   logic out;

   // Set the digital output when the analog input crosses
   // above the high logic threshold.
   always @(above(V(in) - vh)) begin
      out = 1;
   end

   // Clear the digital output when the analog input crosses
   // below the low logic threshold.
   always @(above(vl - V(in))) begin
      out = 0;
   end

   // Model the input capacitance seen by the analog source.
   analog begin
      I(in) <+ c * ddt(V(in));
   end

endmodule
