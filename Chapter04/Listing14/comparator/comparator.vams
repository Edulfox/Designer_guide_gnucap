//////////////////////////////////////////////////////////////////////////////
// Copyright 2026 IHP-Open-PDK Authors
//
// Licensed under the Apache License, Version 2.0 (the "License");
// you may not use this file except in compliance with the License.
// You may obtain a copy of the License at
//
//     https://www.apache.org/licenses/LICENSE-2.0
//
// Unless required by applicable law or agreed to in writing, software
// distributed under the License is distributed on an "AS IS" BASIS,
// WITHOUT WARRANTIES OR CONDITIONS OF ANY KIND, either express or implied.
// See the License for the specific language governing permissions and
// limitations under the License.
//////////////////////////////////////////////////////////////////////////////
`include "disciplines.vams"

// Comparator with logic output from Designer's Guide, Chapter 4, Listing 14.
// `timescale is omitted; digital timing is supplied by the testbench logic model.
module comparator (out, p, n);
   parameter real offset = 0;
   parameter real hyst = 0.0 from [0:inf);
   inout p, n;
   output out;
   electrical p, n;
   reg out;
   logic out;
   parameter real thrlo = offset - 0.5*hyst;
   parameter real thrhi = offset + 0.5*hyst;

   always @(above(V(p, n) - thrhi))
       out = 1;

   always @(above(thrlo - V(p, n)))
       out = 0;
endmodule
