//////////////////////////////////////////////////////////////////////////////
// Copyright 2026 IHP-Open-PDK Authors
//
// Licensed under the Apache License, Version 2.0 (the "License");
// you may not use this file except in compliance with the License.
// You may obtain a copy of the License at
//
//     https://www.apache.org/licenses/LICENSE-2.0
//
// Unless required by applicable law or agreed to in writing, software
// distributed under the License is distributed on an "AS IS" BASIS,
// WITHOUT WARRANTIES OR CONDITIONS OF ANY KIND, either express or implied.
// See the License for the specific language governing permissions and
// limitations under the License.
//////////////////////////////////////////////////////////////////////////////
`include "disciplines.vams"

// Resistive digital-control switch from Designer's Guide, Chapter 4, Listing 11.
// `timescale is omitted; digital timing is supplied by the testbench logic model.
// The electrical equation remains analog; only the digital edge-event syntax is
// written in the parenthesized form accepted by the supplied modelgen snapshot.
module switch (p, n, s);
   parameter real ron = 10.0 from (0:inf);
   parameter real roff = 100.0M from (ron:inf);
   parameter real td = 0.0;
   parameter real tr = 20n;
   parameter real tf = 20n;

   input s;
   logic s;
   electrical p, n;
   real reff;

   always @(posedge(s))
       reff = ron;

   always @(negedge(s))
       reff = roff;

   analog begin
       @(initial_step)
           reff = (s ? ron : roff);
       I(p, n) <+ V(p, n) / transition(reff, td, tr, tf);
   end
endmodule
