//////////////////////////////////////////////////////////////////////////////
// Copyright 2026 IHP-Open-PDK Authors
//
// Licensed under the Apache License, Version 2.0 (the "License");
// you may not use this file except in compliance with the License.
// You may obtain a copy of the License at
//
//     https://www.apache.org/licenses/LICENSE-2.0
//
// Unless required by applicable law or agreed to in writing, software
// distributed under the License is distributed on an "AS IS" BASIS,
// WITHOUT WARRANTIES OR CONDITIONS OF ANY KIND, either express or implied.
// See the License for the specific language governing permissions and
// limitations under the License.
//////////////////////////////////////////////////////////////////////////////
`include "disciplines.vams"

// Eight-bit scalar form of the mixed-signal DAC from Designer's Guide,
// Chapter 4, Listing 9.
// The book's input vector is expanded into scalar logic inputs.
// Gnucap compatibility: wreal is not implemented by the supplied modelgen
// snapshot, so the real-valued output is represented as an electrical voltage.
// The book's output delay is preserved with transition(aout, td, 0).
module dac (out, in7, in6, in5, in4, in3, in2, in1, in0, clk);
   parameter real fullscale = 1.0;
   parameter real td = 0.0;
   parameter integer dir = 1 from [-1:1] exclude 0;

   output out;
   electrical out;

   input in7, in6, in5, in4, in3, in2, in1, in0;
   input clk;
   logic in7, in6, in5, in4, in3, in2, in1, in0, clk;

   real aout = 0.0;
   integer weight;
   parameter integer idir = (dir == 1 ? 1 : 0);

   always @(clk) begin
       if (clk == idir) begin
           aout = 0.0;
           weight = 2;
           if (in7) aout = aout + fullscale/weight;
           weight = weight*2;
           if (in6) aout = aout + fullscale/weight;
           weight = weight*2;
           if (in5) aout = aout + fullscale/weight;
           weight = weight*2;
           if (in4) aout = aout + fullscale/weight;
           weight = weight*2;
           if (in3) aout = aout + fullscale/weight;
           weight = weight*2;
           if (in2) aout = aout + fullscale/weight;
           weight = weight*2;
           if (in1) aout = aout + fullscale/weight;
           weight = weight*2;
           if (in0) aout = aout + fullscale/weight;
       end
   end

   analog
       V(out) <+ transition(aout, td, 0);
endmodule
