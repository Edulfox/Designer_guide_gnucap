//////////////////////////////////////////////////////////////////////////////
// Copyright 2026 IHP-Open-PDK Authors
//
// Licensed under the Apache License, Version 2.0 (the "License");
// you may not use this file except in compliance with the License.
// You may obtain a copy of the License at
//
//     https://www.apache.org/licenses/LICENSE-2.0
//
// Unless required by applicable law or agreed to in writing, software
// distributed under the License is distributed on an "AS IS" BASIS,
// WITHOUT WARRANTIES OR CONDITIONS OF ANY KIND, either express or implied.
// See the License for the specific language governing permissions and
// limitations under the License.
//////////////////////////////////////////////////////////////////////////////
`include "disciplines.vams"

// Scalar digital inverter from Designer's Guide, Chapter 4, Listing 3.
// Gnucap compatibility: logical negation is used instead of bitwise negation.
// The unsupported wire declaration is omitted; scalar ports use logic directly.
module inverter (q, a);
   output q;
   input a;
   logic a, q;
   assign q = !a;
endmodule
