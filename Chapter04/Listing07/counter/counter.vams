//////////////////////////////////////////////////////////////////////////////
// Copyright 2026 IHP-Open-PDK Authors
//
// Licensed under the Apache License, Version 2.0 (the "License");
// you may not use this file except in compliance with the License.
// You may obtain a copy of the License at
//
//     https://www.apache.org/licenses/LICENSE-2.0
//
// Unless required by applicable law or agreed to in writing, software
// distributed under the License is distributed on an "AS IS" BASIS,
// WITHOUT WARRANTIES OR CONDITIONS OF ANY KIND, either express or implied.
// See the License for the specific language governing permissions and
// limitations under the License.
//////////////////////////////////////////////////////////////////////////////

`include "disciplines.vams"

// Behavioral counter based on
// The Designer's Guide to Verilog-AMS,
// Chapter 4, Listing 7.

module counter (out, clk);

   parameter integer maxcount = 9;

   input clk;
   output out;

   reg out;
   logic clk, out;

   integer count;

   initial begin
      out = 0;
      count = 0;
   end

   always @(posedge(clk)) begin
      count = count + 1;

      if (count == maxcount) begin
         out = 1;
         count = 0;
      end
      else if (count == 1) begin
         out = 0;
      end
   end

endmodule
