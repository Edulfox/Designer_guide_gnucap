//////////////////////////////////////////////////////////////////////////////
// Copyright 2026 IHP-Open-PDK Authors
//
// Licensed under the Apache License, Version 2.0 (the "License");
// you may not use this file except in compliance with the License.
// You may obtain a copy of the License at
//
//     https://www.apache.org/licenses/LICENSE-2.0
//
// Unless required by applicable law or agreed to in writing, software
// distributed under the License is distributed on an "AS IS" BASIS,
// WITHOUT WARRANTIES OR CONDITIONS OF ANY KIND, either express or implied.
// See the License for the specific language governing permissions and
// limitations under the License.
//////////////////////////////////////////////////////////////////////////////

`include "disciplines.vams"

// Edge-triggered digital D flip-flop from Chapter 4, Listing 5.
// The book's `always @(clk) if(clk)` behavior is preserved using the directly
// supported positive-edge event form.
module dff (q, d, clk);
   output q;
   input d, clk;
   reg q;
   logic q, d, clk;
   always @(posedge(clk))
      q = d;
endmodule
