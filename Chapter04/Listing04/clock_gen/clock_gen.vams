//////////////////////////////////////////////////////////////////////////////
// Copyright 2026 IHP-Open-PDK Authors
//
// Licensed under the Apache License, Version 2.0 (the "License");
// you may not use this file except in compliance with the License.
// You may obtain a copy of the License at
//
//     https://www.apache.org/licenses/LICENSE-2.0
//
// Unless required by applicable law or agreed to in writing, software
// distributed under the License is distributed on an "AS IS" BASIS,
// WITHOUT WARRANTIES OR CONDITIONS OF ANY KIND, either express or implied.
// See the License for the specific language governing permissions and
// limitations under the License.
//////////////////////////////////////////////////////////////////////////////

`include "disciplines.vams"

// Simple clock generator from The Designer's Guide, Chapter 4, Listing 4.
//
// The book uses:
//   initial clk = 0;
//   always #(cycle/2) clk = ~clk;
//
// Current Gnucap/modelgen does not code-generate that procedural-delay form.
// Verilog-AMS permits analog event expressions to trigger digital behavior, so
// the periodic delay is represented by timer() while the output remains a
// digital reg. The first valid timer event establishes a defined 0/1 state;
// startup before that event is subject to the known Gnucap initialization limit.

module clock_gen(clk);

   parameter real cycle = 20n;

   output clk;
   reg clk;

   initial clk = 0;

   always @(timer(cycle/2, cycle/2))
      clk = !clk;

endmodule
