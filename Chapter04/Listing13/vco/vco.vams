//////////////////////////////////////////////////////////////////////////////
// Copyright 2026 IHP-Open-PDK Authors
//
// Licensed under the Apache License, Version 2.0 (the "License");
// you may not use this file except in compliance with the License.
// You may obtain a copy of the License at
//
//     https://www.apache.org/licenses/LICENSE-2.0
//
// Unless required by applicable law or agreed to in writing, software
// distributed under the License is distributed on an "AS IS" BASIS,
// WITHOUT WARRANTIES OR CONDITIONS OF ANY KIND, either express or implied.
// See the License for the specific language governing permissions and
// limitations under the License.
//////////////////////////////////////////////////////////////////////////////

`include "disciplines.vams"
`include "constants.vams"

// Voltage-controlled oscillator with digital output.
module vco (out, ps, ns);

   parameter real f0 = 100k from (0:inf);
   parameter real kvco = 10k;

   input ps, ns;
   output out;

   electrical ps, ns;
   electrical osc;

   reg out;
   logic out;

   initial out = 0;

   analog begin
      V(osc) <+ sin(`M_TWO_PI * idt(f0 + kvco * V(ps, ns), 0));
   end

   always @(cross(V(osc), 0)) begin
      out = !out;
   end

endmodule
