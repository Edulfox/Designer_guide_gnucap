//////////////////////////////////////////////////////////////////////////////
// Copyright 2026 IHP-Open-PDK Authors
//
// Licensed under the Apache License, Version 2.0 (the "License");
// you may not use this file except in compliance with the License.
// You may obtain a copy of the License at
//
//     https://www.apache.org/licenses/LICENSE-2.0
//
// Unless required by applicable law or agreed to in writing, software
// distributed under the License is distributed on an "AS IS" BASIS,
// WITHOUT WARRANTIES OR CONDITIONS OF ANY KIND, either express or implied.
// See the License for the specific language governing permissions and
// limitations under the License.
//////////////////////////////////////////////////////////////////////////////

// The Designer's Guide to Verilog-AMS
// Chapter 4, Listing 20
// Bidirectional connect module with driver access.
//
// This implementation preserves the driver-access architecture
// of the original listing. Gnucap modelgen currently supports
// the initial block used by this model, but driver-access support
// is still required for $driver_count(), $driver_state(), and
// driver_update() before the model can execute faithfully.

`include "disciplines.vams"

connectmodule bidir(a, d);

   parameter real v0 = 0.0;
   parameter real v1 = 5.0;

   parameter real ruon = 1k;
   parameter real ruoff = 1M;
   parameter real rdon = 1k;
   parameter real rdoff = 1M;

   parameter real tr = 1n;
   parameter real tf = 1n;

   parameter real vl = 0.5;
   parameter real vh = 2.7;

   parameter real maxzi = 0.1u;

   parameter real xdelay = 1n;
   parameter real zdelay = 0.5 * xdelay;

   inout a;
   inout d;

   electrical a;
   logic d;

   parameter real guon = 1.0 / ruon;
   parameter real guoff = 1.0 / ruoff;
   parameter real gdon = 1.0 / rdon;
   parameter real gdoff = 1.0 / rdoff;

   real v;
   real r;
   real gu;
   real gd;

   integer vstate;

   logic istate;
   logic inXrange;
   logic outOfZcurrent;
   logic dout;

   reg istate;
   reg inXrange;
   reg outOfZcurrent;
   reg dout;

   integer DrCount;
   integer i;

   integer XCount;
   integer ZCount;
   integer LCount;
   integer HCount;

   assign d = dout;

   initial begin

      dout = 1'bz;

      vstate = 2;
      istate = 0;
      inXrange = 0;
      outOfZcurrent = 0;

      DrCount = $driver_count(d);

      XCount = 0;
      ZCount = 0;
      LCount = 0;
      HCount = 0;

      for (i = 0; i < DrCount; i = i + 1) begin
         case ($driver_state(d, i))
            1'b0:
               LCount = LCount + 1;

            1'b1:
               HCount = HCount + 1;

            1'bx: begin
               XCount = XCount + 1;
               dout = 1'bx;
            end

            1'bz:
               ZCount = ZCount + 1;
         endcase
      end

      gu = (XCount + HCount) * guon
         + (ZCount + LCount) * guoff;

      gd = (XCount + LCount) * gdon
         + (ZCount + HCount) * gdoff;

      r = 1.0 / (gu + gd);
      v = (gu * v1 + gd * v0) / (gu + gd);

   end

   always @(driver_update(d)) begin

      XCount = 0;
      ZCount = 0;
      LCount = 0;
      HCount = 0;

      for (i = 0; i < DrCount; i = i + 1) begin
         case ($driver_state(d, i))
            1'b0:
               LCount = LCount + 1;

            1'b1:
               HCount = HCount + 1;

            1'bx: begin
               XCount = XCount + 1;
               dout = 1'bx;
            end

            1'bz:
               ZCount = ZCount + 1;
         endcase
      end

      gu = (XCount + HCount) * guon
         + (ZCount + LCount) * guoff;

      gd = (XCount + LCount) * gdon
         + (ZCount + HCount) * gdoff;

      r = 1.0 / (gu + gd);
      v = (gu * v1 + gd * v0) / (gu + gd);

   end

   always @(above(V(a) - vh)) begin
      vstate = 1;
      inXrange = 0;
   end

   always @(above(vh - V(a)))
      inXrange = 1;

   always @(above(V(a) - vl))
      inXrange = 1;

   always @(above(vl - V(a))) begin
      vstate = 3;
      inXrange = 0;
   end

   always @(posedge(inXrange)) begin : XRangeDelay
      #xdelay
      vstate = 2;
      inXrange = 0;
   end

   always @(negedge(inXrange))
      disable XRangeDelay;

   always @(posedge(outOfZcurrent)) begin : outOfZCurrentDelay
      #zdelay
      istate = 1;
      outOfZcurrent = 0;
   end

   always @(negedge(outOfZcurrent))
      disable outOfZCurrentDelay;

   always @(above(abs(I(a)) - maxzi))
      outOfZcurrent = 1;

   always @(above(maxzi - abs(I(a)))) begin
      istate = 0;
      outOfZcurrent = 0;
   end

   always @(vstate or istate or d) begin

      case (vstate)

         1:
            dout = (d === 1'bx) ? 1'bx : 1'b1;

         2:
            dout = ((istate === 1'b0) && (d === 1'bz))
                 ? 1'bz : 1'bx;

         3:
            dout = (d === 1'bx) ? 1'bx : 1'b0;

      endcase

   end

   analog begin
      V(a) <+ transition(v, 0, tr, tf)
              + transition(r, 0, tr, tf) * I(a);
   end

endconnectmodule
