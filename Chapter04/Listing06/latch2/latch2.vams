//////////////////////////////////////////////////////////////////////////////
// Copyright 2026 IHP-Open-PDK Authors
//
// Licensed under the Apache License, Version 2.0 (the "License");
// you may not use this file except in compliance with the License.
// You may obtain a copy of the License at
//
//     https://www.apache.org/licenses/LICENSE-2.0
//
// Unless required by applicable law or agreed to in writing, software
// distributed under the License is distributed on an "AS IS" BASIS,
// WITHOUT WARRANTIES OR CONDITIONS OF ANY KIND, either express or implied.
// See the License for the specific language governing permissions and
// limitations under the License.
//////////////////////////////////////////////////////////////////////////////

`include "disciplines.vams"

// Two-input latch from The Designer's Guide, Chapter 4, Listing 6.
// The book's two-bit output vector is expanded into scalar outputs.
// Gnucap compatibility: wait(!en) is represented using supported events.
// Data changes update while en is low; a falling en edge releases the pending
// wait condition and captures the current d1/d2 values.
module latch2 (out0, out1, d1, d2, en);
   output out0, out1;
   input d1, d2, en;
   reg out0, out1;
   logic out0, out1, d1, d2, en;

   always @(edge(d1) or edge(d2)) begin
      if (!en) begin
         out0 = d1;
         out1 = d2;
      end
   end

   always @(negedge(en)) begin
      out0 = d1;
      out1 = d2;
   end
endmodule
