////////////////////////////////////////////////////////////////////////
//
// Copyright 2026 IHP PDK Authors
//
// Licensed under the Apache License, Version 2.0 (the "License");
// you may not use this file except in compliance with the License.
// You may obtain a copy of the License at
//
//    https://www.apache.org/licenses/LICENSE-2.0
//
// Unless required by applicable law or agreed to in writing, software
// distributed under the License is distributed on an "AS IS" BASIS,
// WITHOUT WARRANTIES OR CONDITIONS OF ANY KIND, either express or implied.
// See the License for the specific language governing permissions and
// limitations under the License.
//
////////////////////////////////////////////////////////////////////////

// Original digital-logic registered comparator from comp/comp_reg.
// The clock and the outputs are logic nets; comp_reg_logic_tb.gc bridges
// them to the analog domain with elect_to_logic / logic_to_elect.

`include "disciplines.vams"

module comparator_reg(outp, outn, inp, inn, clk, vdd, vss);
    parameter real vos = 0.0;
    parameter real meta = 0.0 from [0:inf);
    output outp, outn;
    reg outp, outn;
    input inp, inn, clk, vdd, vss;

    logic outp, outn, clk;
    electrical inp, inn, vdd, vss;

    always @(posedge(clk)) begin
            if (V(inp) - V(inn) + vos > meta) begin
                outp = 1;
                outn = 0;
            end
            else begin
                outp = 0;
                outn = 1;
            end
    end
    always @(negedge(clk)) outp = 1;
    always @(negedge(clk)) outn = 1;

endmodule
