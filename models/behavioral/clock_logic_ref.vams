////////////////////////////////////////////////////////////////////////
//
// Copyright 2026 IHP PDK Authors
//
// Licensed under the Apache License, Version 2.0 (the "License");
// you may not use this file except in compliance with the License.
// You may obtain a copy of the License at
//
//    https://www.apache.org/licenses/LICENSE-2.0
//
// Unless required by applicable law or agreed to in writing, software
// distributed under the License is distributed on an "AS IS" BASIS,
// WITHOUT WARRANTIES OR CONDITIONS OF ANY KIND, either express or implied.
// See the License for the specific language governing permissions and
// limitations under the License.
//
////////////////////////////////////////////////////////////////////////

// Original digital-logic clock from comp/comp_reg: a gated 50 % square
// wave on a logic net, used through a c_d_a connect module.

`include "disciplines.vams"

module clock(out, en);
  output out;
  input en;
  logic out, en;
  assign #10000 out = !out & en;
endmodule
