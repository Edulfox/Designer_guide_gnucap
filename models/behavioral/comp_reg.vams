//////////////////////////////////////////////////////////////////////
//
// Copyright 2026 IHP PDK Authors
//
// Licensed under the Apache License, Version 2.0 (the "License");
// you may not use this file except in compliance with the License.
// You may obtain a copy of the License at
//
//    https://www.apache.org/licenses/LICENSE-2.0
//
// Unless required by applicable law or agreed to in writing, software
// distributed under the License is distributed on an "AS IS" BASIS,
// WITHOUT WARRANTIES OR CONDITIONS OF ANY KIND, either express or implied.
// See the License for the specific language governing permissions and
// limitations under the License.
//
// Clocked comparator with registered (latched) outputs.
//
// Source: comp/comp_reg (digital-logic original) rewritten in analog-style
// Verilog-A so that it builds with the current gnucap-mg-vams.
//
// Behaviour:
//   clk low                -> outp = outn = vdd   (reset / precharge)
//   rising clk, inp > inn  -> outp = vdd, outn = vss
//   rising clk, inp < inn  -> outp = vss, outn = vdd
//   result is registered until the next falling clock edge
//
// Two modules are provided:
//   clock        : gated clock generator (enables with en)
//   comparator_reg : registered comparator core
//
//////////////////////////////////////////////////////////////////////

`include "constants.vams"
`include "disciplines.vams"

module clock(out, en);

output out;
input en;

electrical out, en;

parameter real ven_th = 2.5;
parameter real vlow = 0.0;
parameter real vhigh = 1.2;
parameter real half_period = 5n;
parameter real trise = 10p;
parameter real tfall = 10p;

integer state = 0;

analog begin
    @(timer(0, half_period)) begin
        if (V(en) > ven_th) begin
            state = !state;
        end
        else begin
            state = 0;
        end
    end

    @(cross(V(en) - ven_th, -1)) state = 0;

    V(out) <+ transition(state ? vhigh : vlow, 0, trise, tfall);
end

endmodule

module comparator_reg (inp, inn, clk, outp, outn, vdd, vss);

input inp, inn, clk, vdd, vss;
output outp, outn;

electrical inp, inn, clk;
electrical outp, outn;
electrical vdd, vss;

parameter real vclk_th = 0.6;
parameter real vos = 0.0;
parameter real tdelay = 200p;
parameter real trise = 30p;
parameter real meta = 100u;

// registered state: 0 = reset, 1 = inp > inn, -1 = inp < inn
integer state = 0;

real vhigh;
real vlow;
real voutp_target;
real voutn_target;

analog begin

    @(cross(V(clk) - vclk_th, +1)) begin
        if (V(inp) - V(inn) + vos > meta) begin
            state = 1;
        end
        else if (V(inp) - V(inn) + vos < -meta) begin
            state = -1;
        end
    end

    @(cross(V(clk) - vclk_th, -1)) state = 0;

    vhigh = V(vdd);
    vlow = V(vss);
    if (state == 0) begin
        voutp_target = vhigh;
        voutn_target = vhigh;
    end
    else if (state > 0) begin
        voutp_target = vhigh;
        voutn_target = vlow;
    end
    else begin
        voutp_target = vlow;
        voutn_target = vhigh;
    end

    V(outp) <+ transition(voutp_target, tdelay, trise);
    V(outn) <+ transition(voutn_target, tdelay, trise);

end

endmodule
