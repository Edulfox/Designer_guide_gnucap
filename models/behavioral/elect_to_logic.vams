////////////////////////////////////////////////////////////////////////
//
// Copyright 2026 IHP PDK Authors
//
// Licensed under the Apache License, Version 2.0 (the "License");
// you may not use this file except in compliance with the License.
// You may obtain a copy of the License at
//
//    https://www.apache.org/licenses/LICENSE-2.0
//
// Unless required by applicable law or agreed to in writing, software
// distributed under the License is distributed on an "AS IS" BASIS,
// WITHOUT WARRANTIES OR CONDITIONS OF ANY KIND, either express or implied.
// See the License for the specific language governing permissions and
// limitations under the License.
//
////////////////////////////////////////////////////////////////////////

// Electrical-to-logic connectmodule, as used in the IHP SG13G2 gnucap
// mixed-signal examples. Explicit thresholds are 0.85 V and 0.25 V.
`include "disciplines.vams"

connectmodule elect_to_logic(el, cm);
input el;
output cm;
logic cm;
electrical el;
reg state;
logic state;

initial state = 0;
always @(above(V(el) - 0.85)) state = 1;
always @(above(0.25 - V(el))) state = 0;
assign cm = state;
endconnectmodule
