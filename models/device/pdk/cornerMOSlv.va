//******************************************************************************
//
// Copyright 2026 IHP PDK Authors
//
// Licensed under the Apache License, Version 2.0 (the "License");
// you may not use this file except in compliance with the License.
// You may obtain a copy of the License at
//
//    https://www.apache.org/licenses/LICENSE-2.0
//
// Unless required by applicable law or agreed to in writing, software
// distributed under the License is distributed on an "AS IS" BASIS,
// WITHOUT WARRANTIES OR CONDITIONS OF ANY KIND, either express or implied.
// See the License for the specific language governing permissions and
// limitations under the License.
//
//******************************************************************************
//******************************************************************************
//
//
//                            M O S     C O R N E R S
//
//
//******************************************************************************
//
// Corner naming scheme: typical mean=tt, worst case=ss, best case=ff, combinations sf, fs, ...
// Digit Devices

//******************************************************************************
// MOSLV corner modules
//
// Adapted from `ngspice/models/cornerMOSlv.lib`
//
// Modifications:
// - Removed mismatch corners; mismatch is implemented in paramsets
// - Moved global process-variation parameters into the statistical corner
//******************************************************************************

(* desc = "Typical Low-Voltage SG13G2 MOS corner (tt: typical n, typical p)" *)
module moslv_tt();
    // nmos
    parameter real sg13g2_lv_nmos_vfbo = 1.0;
    parameter real sg13g2_lv_nmos_ctl = 1.2080;
    parameter real sg13g2_lv_nmos_rsw1 = 0.7200;
    parameter real sg13g2_lv_nmos_muew = 0.8500;
    parameter real sg13g2_lv_nmos_dphibo = 0.9915;
    parameter real sg13g2_lv_nmos_dphibl = 0.9693;
    parameter real sg13g2_lv_nmos_dphibw = 0.9749;
    parameter real sg13g2_lv_nmos_dphiblw = 0.9754;
    parameter real sg13g2_lv_nmos_themuo = 0.8757;
    parameter real sg13g2_lv_nmos_thesatl = 0.7850;
    parameter real sg13g2_lv_nmos_thesatw = 1.5000;
    parameter real sg13g2_lv_nmos_thesatlw = 0.6127;
    parameter real sg13g2_lv_nmos_toxo = 1.0000;
    parameter real sg13g2_lv_nmos_toxovo = 1.0000;
    parameter real sg13g2_lv_nmos_cjorbot = 1.0000;
    parameter real sg13g2_lv_nmos_cjorsti = 1.0000;
    parameter real sg13g2_lv_nmos_cjorgat = 1.0000;
    // pmos
    parameter real sg13g2_lv_pmos_vfbo = 1.0;
    parameter real sg13g2_lv_pmos_ctl = 1.9570;
    parameter real sg13g2_lv_pmos_rsw1 = 0.7720;
    parameter real sg13g2_lv_pmos_muew = 1.0520;
    parameter real sg13g2_lv_pmos_dphibo = 0.9050;
    parameter real sg13g2_lv_pmos_dphibl = 0.8550;
    parameter real sg13g2_lv_pmos_dphibw = -1.5800;
    parameter real sg13g2_lv_pmos_dphiblw = 1.0000;
    parameter real sg13g2_lv_pmos_themuo = 0.9580;
    parameter real sg13g2_lv_pmos_thesatl = 0.5510;
    parameter real sg13g2_lv_pmos_thesatw = 1.0800;
    parameter real sg13g2_lv_pmos_thesatlw = 1.0000;
    parameter real sg13g2_lv_pmos_toxo = 1.0000;
    parameter real sg13g2_lv_pmos_toxovo = 1.0000;
    parameter real sg13g2_lv_pmos_cjorbot = 1.0000;
    parameter real sg13g2_lv_pmos_cjorsti = 1.0000;
    parameter real sg13g2_lv_pmos_cjorgat = 1.0000;
    // svaricaplv
    parameter real sg13g2_lv_svaricap_lap = 1.082;
    parameter real sg13g2_lv_svaricap_toxo = 1;
endmodule

(* desc = "Worst-case Low-Voltage SG13G2 MOS corner (ss: slow n, slow p)" *)
module moslv_ss();
    // nmos
    parameter real sg13g2_lv_nmos_vfbo = 1.0;
    parameter real sg13g2_lv_nmos_ctl = 0.4939;
    parameter real sg13g2_lv_nmos_rsw1 = 0.6560;
    parameter real sg13g2_lv_nmos_muew = 0.9700;
    parameter real sg13g2_lv_nmos_dphibo = 1.2070;
    parameter real sg13g2_lv_nmos_dphibl = 1.3360;
    parameter real sg13g2_lv_nmos_dphibw = 1.3290;
    parameter real sg13g2_lv_nmos_dphiblw = 1.0110;
    parameter real sg13g2_lv_nmos_themuo = 0.8866;
    parameter real sg13g2_lv_nmos_thesatl = 1.0960;
    parameter real sg13g2_lv_nmos_thesatw = 1.5930;
    parameter real sg13g2_lv_nmos_thesatlw = 0.9875;
    parameter real sg13g2_lv_nmos_toxo = 1.0400;
    parameter real sg13g2_lv_nmos_toxovo = 1.0400;
    parameter real sg13g2_lv_nmos_cjorbot = 1.0800;
    parameter real sg13g2_lv_nmos_cjorsti = 1.0800;
    parameter real sg13g2_lv_nmos_cjorgat = 1.0800;
    // pmos
    parameter real sg13g2_lv_pmos_vfbo = 1.0;
    parameter real sg13g2_lv_pmos_ctl = 1.3520;
    parameter real sg13g2_lv_pmos_rsw1 = 0.9365;
    parameter real sg13g2_lv_pmos_muew = 1.1030;
    parameter real sg13g2_lv_pmos_dphibo = 0.5883;
    parameter real sg13g2_lv_pmos_dphibl = 1.3540;
    parameter real sg13g2_lv_pmos_dphibw = -4.9920;
    parameter real sg13g2_lv_pmos_dphiblw = 1.0000;
    parameter real sg13g2_lv_pmos_themuo = 0.8720;
    parameter real sg13g2_lv_pmos_thesatl = 1.2190;
    parameter real sg13g2_lv_pmos_thesatw = 0.9875;
    parameter real sg13g2_lv_pmos_thesatlw = 1.0000;
    parameter real sg13g2_lv_pmos_toxo = 1.0400;
    parameter real sg13g2_lv_pmos_toxovo = 1.0400;
    parameter real sg13g2_lv_pmos_cjorbot = 1.0800;
    parameter real sg13g2_lv_pmos_cjorsti = 1.0800;
    parameter real sg13g2_lv_pmos_cjorgat = 1.0800;
    // svaricaplv
    parameter real sg13g2_lv_svaricap_lap = 1;
    parameter real sg13g2_lv_svaricap_toxo = 1.04;
endmodule

(* desc = "Best-case Low-Voltage SG13G2 MOS corner (ff: fast n, fast p)" *)
module moslv_ff();
    // nmos
    parameter real sg13g2_lv_nmos_vfbo = 1.0;
    parameter real sg13g2_lv_nmos_ctl = 1.4310;
    parameter real sg13g2_lv_nmos_rsw1 = 0.9000;
    parameter real sg13g2_lv_nmos_muew = 0.7780;
    parameter real sg13g2_lv_nmos_dphibo = 0.8137;
    parameter real sg13g2_lv_nmos_dphibl = 0.6550;
    parameter real sg13g2_lv_nmos_dphibw = 0.6105;
    parameter real sg13g2_lv_nmos_dphiblw = 0.9300;
    parameter real sg13g2_lv_nmos_themuo = 0.8708;
    parameter real sg13g2_lv_nmos_thesatl = 0.5510;
    parameter real sg13g2_lv_nmos_thesatw = 1.4300;
    parameter real sg13g2_lv_nmos_thesatlw = 0.0860;
    parameter real sg13g2_lv_nmos_toxo = 0.9600;
    parameter real sg13g2_lv_nmos_toxovo = 0.9600;
    parameter real sg13g2_lv_nmos_cjorbot = 0.9200;
    parameter real sg13g2_lv_nmos_cjorsti = 0.9200;
    parameter real sg13g2_lv_nmos_cjorgat = 0.9200;
    // pmos
    parameter real sg13g2_lv_pmos_vfbo = 1.0;
    parameter real sg13g2_lv_pmos_ctl = 2.4800;
    parameter real sg13g2_lv_pmos_rsw1 = 0.5000;
    parameter real sg13g2_lv_pmos_muew = 0.9620;
    parameter real sg13g2_lv_pmos_dphibo = 1.2350;
    parameter real sg13g2_lv_pmos_dphibl = 0.5066;
    parameter real sg13g2_lv_pmos_dphibw = 3.9230;
    parameter real sg13g2_lv_pmos_dphiblw = 1.0000;
    parameter real sg13g2_lv_pmos_themuo = 1.0200;
    parameter real sg13g2_lv_pmos_thesatl = 0.1880;
    parameter real sg13g2_lv_pmos_thesatw = 1.2440;
    parameter real sg13g2_lv_pmos_thesatlw = 2.0000;
    parameter real sg13g2_lv_pmos_toxo = 0.9600;
    parameter real sg13g2_lv_pmos_toxovo = 0.9600;
    parameter real sg13g2_lv_pmos_cjorbot = 0.9200;
    parameter real sg13g2_lv_pmos_cjorsti = 0.9200;
    parameter real sg13g2_lv_pmos_cjorgat = 0.9200;
    // svaricaplv
    parameter real sg13g2_lv_svaricap_lap = 1.24;
    parameter real sg13g2_lv_svaricap_toxo = 0.96;
endmodule

(* desc = "Slow/Fast Low-Voltage SG13G2 MOS corner (sf: slow n, fast p)" *)
module moslv_sf();
    // nmos
    parameter real sg13g2_lv_nmos_vfbo = 1.0;
    parameter real sg13g2_lv_nmos_ctl = 0.8509;
    parameter real sg13g2_lv_nmos_rsw1 = 0.6880;
    parameter real sg13g2_lv_nmos_muew = 0.9100;
    parameter real sg13g2_lv_nmos_dphibo = 1.0993;
    parameter real sg13g2_lv_nmos_dphibl = 1.1526;
    parameter real sg13g2_lv_nmos_dphibw = 1.1520;
    parameter real sg13g2_lv_nmos_dphiblw = 0.9932;
    parameter real sg13g2_lv_nmos_themuo = 0.8812;
    parameter real sg13g2_lv_nmos_thesatl = 0.9405;
    parameter real sg13g2_lv_nmos_thesatw = 1.5465;
    parameter real sg13g2_lv_nmos_thesatlw = 0.8001;
    parameter real sg13g2_lv_nmos_toxo = 1.0200;
    parameter real sg13g2_lv_nmos_toxovo = 1.0200;
    parameter real sg13g2_lv_nmos_cjorbot = 1.0400;
    parameter real sg13g2_lv_nmos_cjorsti = 1.0400;
    parameter real sg13g2_lv_nmos_cjorgat = 1.0400;
    // pmos
    parameter real sg13g2_lv_pmos_vfbo = 1.0;
    parameter real sg13g2_lv_pmos_ctl = 2.2185;
    parameter real sg13g2_lv_pmos_rsw1 = 0.6360;
    parameter real sg13g2_lv_pmos_muew = 1.0070;
    parameter real sg13g2_lv_pmos_dphibo = 1.0700;
    parameter real sg13g2_lv_pmos_dphibl = 0.6808;
    parameter real sg13g2_lv_pmos_dphibw = 1.1715;
    parameter real sg13g2_lv_pmos_dphiblw = 1.0000;
    parameter real sg13g2_lv_pmos_themuo = 0.9890;
    parameter real sg13g2_lv_pmos_thesatl = 0.3695;
    parameter real sg13g2_lv_pmos_thesatw = 1.1620;
    parameter real sg13g2_lv_pmos_thesatlw = 1.5000;
    parameter real sg13g2_lv_pmos_toxo = 0.9800;
    parameter real sg13g2_lv_pmos_toxovo = 0.9800;
    parameter real sg13g2_lv_pmos_cjorbot = 0.9600;
    parameter real sg13g2_lv_pmos_cjorsti = 0.9600;
    parameter real sg13g2_lv_pmos_cjorgat = 0.9600;
    // svaricaplv
    parameter real sg13g2_lv_svaricap_lap = 1.161;
    parameter real sg13g2_lv_svaricap_toxo = 0.98;
endmodule

(* desc = "Fast/Slow Low-Voltage SG13G2 MOS corner (fs: fast n, slow p)" *)
module moslv_fs();
    // nmos
    parameter real sg13g2_lv_nmos_vfbo = 1.0;
    parameter real sg13g2_lv_nmos_ctl = 1.3195;
    parameter real sg13g2_lv_nmos_rsw1 = 0.8100;
    parameter real sg13g2_lv_nmos_muew = 0.8140;
    parameter real sg13g2_lv_nmos_dphibo = 0.9026;
    parameter real sg13g2_lv_nmos_dphibl = 0.8122;
    parameter real sg13g2_lv_nmos_dphibw = 0.7927;
    parameter real sg13g2_lv_nmos_dphiblw = 0.9527;
    parameter real sg13g2_lv_nmos_themuo = 0.8733;
    parameter real sg13g2_lv_nmos_thesatl = 0.6680;
    parameter real sg13g2_lv_nmos_thesatw = 1.4650;
    parameter real sg13g2_lv_nmos_thesatlw = 0.3493;
    parameter real sg13g2_lv_nmos_toxo = 0.9800;
    parameter real sg13g2_lv_nmos_toxovo = 0.9800;
    parameter real sg13g2_lv_nmos_cjorbot = 0.9600;
    parameter real sg13g2_lv_nmos_cjorsti = 0.9600;
    parameter real sg13g2_lv_nmos_cjorgat = 0.9600;
    // pmos
    parameter real sg13g2_lv_pmos_vfbo = 1.0;
    parameter real sg13g2_lv_pmos_ctl = 1.6545;
    parameter real sg13g2_lv_pmos_rsw1 = 0.8542;
    parameter real sg13g2_lv_pmos_muew = 1.0775;
    parameter real sg13g2_lv_pmos_dphibo = 0.7467;
    parameter real sg13g2_lv_pmos_dphibl = 1.1045;
    parameter real sg13g2_lv_pmos_dphibw = -3.2860;
    parameter real sg13g2_lv_pmos_dphiblw = 1.0000;
    parameter real sg13g2_lv_pmos_themuo = 0.9150;
    parameter real sg13g2_lv_pmos_thesatl = 0.8850;
    parameter real sg13g2_lv_pmos_thesatw = 1.0337;
    parameter real sg13g2_lv_pmos_thesatlw = 1.0000;
    parameter real sg13g2_lv_pmos_toxo = 1.0200;
    parameter real sg13g2_lv_pmos_toxovo = 1.0200;
    parameter real sg13g2_lv_pmos_cjorbot = 1.0400;
    parameter real sg13g2_lv_pmos_cjorsti = 1.0400;
    parameter real sg13g2_lv_pmos_cjorgat = 1.0400;
    // svaricaplv
    parameter real sg13g2_lv_svaricap_lap = 1.041;
    parameter real sg13g2_lv_svaricap_toxo = 1.02;
endmodule

(* desc = "Typical statistical Low-Voltage SG13G2 MOS corner (tt: typical n, typical p)" *)
module moslv_tt_stat();
    parameter integer seed = 0;
    // nmos nominal
    parameter real sg13g2_lv_nmos_vfbo_nom     = 1.0;
    parameter real sg13g2_lv_nmos_ctl_nom      = 1.2080;
    parameter real sg13g2_lv_nmos_rsw1_nom     = 0.7200;
    parameter real sg13g2_lv_nmos_muew_nom     = 0.8500;
    parameter real sg13g2_lv_nmos_dphibo_nom   = 0.9915;
    parameter real sg13g2_lv_nmos_dphibl_nom   = 0.9693;
    parameter real sg13g2_lv_nmos_dphibw_nom   = 0.9749;
    parameter real sg13g2_lv_nmos_dphiblw_nom  = 0.9754;
    parameter real sg13g2_lv_nmos_themuo_nom   = 0.8757;
    parameter real sg13g2_lv_nmos_thesatl_nom  = 0.7850;
    parameter real sg13g2_lv_nmos_thesatw_nom  = 1.5000;
    parameter real sg13g2_lv_nmos_thesatlw_nom = 0.6127;
    parameter real sg13g2_lv_nmos_toxo_nom     = 1.0000;
    parameter real sg13g2_lv_nmos_toxovo_nom   = 1.0000;
    parameter real sg13g2_lv_nmos_cjorbot_nom  = 1.0000;
    parameter real sg13g2_lv_nmos_cjorsti_nom  = 1.0000;
    parameter real sg13g2_lv_nmos_cjorgat_nom  = 1.0000;
    // nmos sigma
    parameter real sg13g2_lv_nmos_vfbo_sig     = 0.0050 * sg13g2_lv_nmos_vfbo_nom;
    parameter real sg13g2_lv_nmos_ctl_sig      = 0.1562 * sg13g2_lv_nmos_ctl_nom;
    parameter real sg13g2_lv_nmos_rsw1_sig     = 0.0407 * sg13g2_lv_nmos_rsw1_nom;
    parameter real sg13g2_lv_nmos_muew_sig     = 0.0320 * sg13g2_lv_nmos_muew_nom;
    parameter real sg13g2_lv_nmos_dphibo_sig   = 0.0656 * sg13g2_lv_nmos_dphibo_nom;
    parameter real sg13g2_lv_nmos_dphibl_sig   = 0.1135 * sg13g2_lv_nmos_dphibl_nom;
    parameter real sg13g2_lv_nmos_dphibw_sig   = 0.1197 * sg13g2_lv_nmos_dphibw_nom;
    parameter real sg13g2_lv_nmos_dphiblw_sig  = 0.0135 * sg13g2_lv_nmos_dphiblw_nom;
    parameter real sg13g2_lv_nmos_themuo_sig   = 0.0026 * sg13g2_lv_nmos_themuo_nom;
    parameter real sg13g2_lv_nmos_thesatl_sig  = 0.0908 * sg13g2_lv_nmos_thesatl_nom;
    parameter real sg13g2_lv_nmos_thesatw_sig  = 0.0272 * sg13g2_lv_nmos_thesatw_nom;
    parameter real sg13g2_lv_nmos_thesatlw_sig = 0.1503 * sg13g2_lv_nmos_thesatlw_nom;
    parameter real sg13g2_lv_nmos_toxo_sig     = 0.0133 * sg13g2_lv_nmos_toxo_nom;
    parameter real sg13g2_lv_nmos_toxovo_sig   = 0.0133 * sg13g2_lv_nmos_toxovo_nom;
    parameter real sg13g2_lv_nmos_cjorbot_sig  = 0.0267 * sg13g2_lv_nmos_cjorbot_nom;
    parameter real sg13g2_lv_nmos_cjorsti_sig  = 0.0267 * sg13g2_lv_nmos_cjorsti_nom;
    parameter real sg13g2_lv_nmos_cjorgat_sig  = 0.0267 * sg13g2_lv_nmos_cjorgat_nom;
    // nmos params with global process variation
    parameter real sg13g2_lv_nmos_vfbo     = (sg13g2_lv_nmos_vfbo_nom);
    parameter real sg13g2_lv_nmos_ctl      = (sg13g2_lv_nmos_ctl_nom);
    parameter real sg13g2_lv_nmos_rsw1     = (sg13g2_lv_nmos_rsw1_nom);
    parameter real sg13g2_lv_nmos_muew     = (sg13g2_lv_nmos_muew_nom);
    parameter real sg13g2_lv_nmos_dphibo   = (sg13g2_lv_nmos_dphibo_nom);
    parameter real sg13g2_lv_nmos_dphibl   = (sg13g2_lv_nmos_dphibl_nom);
    parameter real sg13g2_lv_nmos_dphibw   = (sg13g2_lv_nmos_dphibw_nom);
    parameter real sg13g2_lv_nmos_dphiblw  = (sg13g2_lv_nmos_dphiblw_nom);
    parameter real sg13g2_lv_nmos_themuo   = (sg13g2_lv_nmos_themuo_nom);
    parameter real sg13g2_lv_nmos_thesatl  = (sg13g2_lv_nmos_thesatl_nom);
    parameter real sg13g2_lv_nmos_thesatw  = (sg13g2_lv_nmos_thesatw_nom);
    parameter real sg13g2_lv_nmos_thesatlw = (sg13g2_lv_nmos_thesatlw_nom);
    parameter real sg13g2_lv_nmos_toxo     = (sg13g2_lv_nmos_toxo_nom);
    parameter real sg13g2_lv_nmos_toxovo   = (sg13g2_lv_nmos_toxovo_nom);
    parameter real sg13g2_lv_nmos_cjorbot  = (sg13g2_lv_nmos_cjorbot_nom);
    parameter real sg13g2_lv_nmos_cjorsti  = (sg13g2_lv_nmos_cjorsti_nom);
    parameter real sg13g2_lv_nmos_cjorgat  = (sg13g2_lv_nmos_cjorgat_nom);
    // pmos nominal
    parameter real sg13g2_lv_pmos_vfbo_nom     = 1.0;
    parameter real sg13g2_lv_pmos_ctl_nom      = 1.9570;
    parameter real sg13g2_lv_pmos_rsw1_nom     = 0.7720;
    parameter real sg13g2_lv_pmos_muew_nom     = 1.0520;
    parameter real sg13g2_lv_pmos_dphibo_nom   = 0.9050;
    parameter real sg13g2_lv_pmos_dphibl_nom   = 0.8550;
    parameter real sg13g2_lv_pmos_dphibw_nom   = -1.5800;
    parameter real sg13g2_lv_pmos_dphiblw_nom  = 1.0000;
    parameter real sg13g2_lv_pmos_themuo_nom   = 0.9580;
    parameter real sg13g2_lv_pmos_thesatl_nom  = 0.5510;
    parameter real sg13g2_lv_pmos_thesatw_nom  = 1.0800;
    parameter real sg13g2_lv_pmos_thesatlw_nom = 1.0000;
    parameter real sg13g2_lv_pmos_toxo_nom     = 1.0000;
    parameter real sg13g2_lv_pmos_toxovo_nom   = 1.0000;
    parameter real sg13g2_lv_pmos_cjorbot_nom  = 1.0000;
    parameter real sg13g2_lv_pmos_cjorsti_nom  = 1.0000;
    parameter real sg13g2_lv_pmos_cjorgat_nom  = 1.0000;
    // pmos sigma
    parameter real sg13g2_lv_pmos_vfbo_sig     = 0.0050 * sg13g2_lv_pmos_vfbo_nom;
    parameter real sg13g2_lv_pmos_ctl_sig      = 0.1880 * sg13g2_lv_pmos_ctl_nom;
    parameter real sg13g2_lv_pmos_rsw1_sig     = 0.0727 * sg13g2_lv_pmos_rsw1_nom;
    parameter real sg13g2_lv_pmos_muew_sig     = 0.0235 * sg13g2_lv_pmos_muew_nom;
    parameter real sg13g2_lv_pmos_dphibo_sig   = 0.1078 * sg13g2_lv_pmos_dphibo_nom;
    parameter real sg13g2_lv_pmos_dphibl_sig   = 0.1412 * sg13g2_lv_pmos_dphibl_nom;
    parameter real sg13g2_lv_pmos_dphibw_sig   = 1.4858 * sg13g2_lv_pmos_dphibw_nom;
    parameter real sg13g2_lv_pmos_dphiblw_sig  = 1.0e-9 * sg13g2_lv_pmos_dphiblw_nom;
    parameter real sg13g2_lv_pmos_themuo_sig   = 0.0247 * sg13g2_lv_pmos_themuo_nom;
    parameter real sg13g2_lv_pmos_thesatl_sig  = 0.1718 * sg13g2_lv_pmos_thesatl_nom;
    parameter real sg13g2_lv_pmos_thesatw_sig  = 0.0427 * sg13g2_lv_pmos_thesatw_nom;
    parameter real sg13g2_lv_pmos_thesatlw_sig = 0.1667 * sg13g2_lv_pmos_thesatlw_nom;
    parameter real sg13g2_lv_pmos_toxo_sig     = 0.0133 * sg13g2_lv_pmos_toxo_nom;
    parameter real sg13g2_lv_pmos_toxovo_sig   = 0.0133 * sg13g2_lv_pmos_toxovo_nom;
    parameter real sg13g2_lv_pmos_cjorbot_sig  = 0.0267 * sg13g2_lv_pmos_cjorbot_nom;
    parameter real sg13g2_lv_pmos_cjorsti_sig  = 0.0267 * sg13g2_lv_pmos_cjorsti_nom;
    parameter real sg13g2_lv_pmos_cjorgat_sig  = 0.0267 * sg13g2_lv_pmos_cjorgat_nom;
    // pmos params with global process variation
    parameter real sg13g2_lv_pmos_vfbo     = (sg13g2_lv_pmos_vfbo_nom);
    parameter real sg13g2_lv_pmos_ctl      = (sg13g2_lv_pmos_ctl_nom);
    parameter real sg13g2_lv_pmos_rsw1     = (sg13g2_lv_pmos_rsw1_nom);
    parameter real sg13g2_lv_pmos_muew     = (sg13g2_lv_pmos_muew_nom);
    parameter real sg13g2_lv_pmos_dphibo   = (sg13g2_lv_pmos_dphibo_nom);
    parameter real sg13g2_lv_pmos_dphibl   = (sg13g2_lv_pmos_dphibl_nom);
    parameter real sg13g2_lv_pmos_dphibw   = (sg13g2_lv_pmos_dphibw_nom);
    parameter real sg13g2_lv_pmos_dphiblw  = (sg13g2_lv_pmos_dphiblw_nom);
    parameter real sg13g2_lv_pmos_themuo   = (sg13g2_lv_pmos_themuo_nom);
    parameter real sg13g2_lv_pmos_thesatl  = (sg13g2_lv_pmos_thesatl_nom);
    parameter real sg13g2_lv_pmos_thesatw  = (sg13g2_lv_pmos_thesatw_nom);
    parameter real sg13g2_lv_pmos_thesatlw = (sg13g2_lv_pmos_thesatlw_nom);
    parameter real sg13g2_lv_pmos_toxo     = (sg13g2_lv_pmos_toxo_nom);
    parameter real sg13g2_lv_pmos_toxovo   = (sg13g2_lv_pmos_toxovo_nom);
    parameter real sg13g2_lv_pmos_cjorbot  = (sg13g2_lv_pmos_cjorbot_nom);
    parameter real sg13g2_lv_pmos_cjorsti  = (sg13g2_lv_pmos_cjorsti_nom);
    parameter real sg13g2_lv_pmos_cjorgat  = (sg13g2_lv_pmos_cjorgat_nom);
    // svaricaplv
    parameter real sg13g2_lv_svaricap_lap = 1.082;
    parameter real sg13g2_lv_svaricap_toxo = 1;
endmodule

// TODO: mm params are hard coded into paramsets, pull out of module instead?
(* desc = "Low-Voltage SG13G2 MOS mismatch parameters" *)
module moslv_mm();
    // nmos
    parameter real sg13g2_lv_nmos_delvto_mm  = 0.0039;
    parameter real sg13g2_lv_nmos_factuo_mm  = 0.005;
    parameter real sg13g2_lv_nmos_dw_mm      = 4e-9;
    parameter real sg13g2_lv_nmos_dl_mm      = 2e-9;
    // pmos
    parameter real sg13g2_lv_pmos_delvto_mm  = 0.0022;
    parameter real sg13g2_lv_pmos_factuo_mm  = 0.0033;
    parameter real sg13g2_lv_pmos_dw_mm      = 4e-9;
    parameter real sg13g2_lv_pmos_dl_mm      = 2e-9;
endmodule
