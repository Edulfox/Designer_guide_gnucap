//******************************************************************************
//
// Copyright 2026 IHP PDK Authors
//
// Licensed under the Apache License, Version 2.0 (the "License");
// you may not use this file except in compliance with the License.
// You may obtain a copy of the License at
//
//    https://www.apache.org/licenses/LICENSE-2.0
//
// Unless required by applicable law or agreed to in writing, software
// distributed under the License is distributed on an "AS IS" BASIS,
// WITHOUT WARRANTIES OR CONDITIONS OF ANY KIND, either express or implied.
// See the License for the specific language governing permissions and
// limitations under the License.
//
//******************************************************************************

//******************************************************************************
// Resistor corner modules
//
// Adapted from ngspice/models/cornerRES.lib
//
// Modifications:
// - Removed mismatch corners; mismatch is implemented in paramsets
// - Renamed dw_par_* and mismatch parameters for consistency
//******************************************************************************

(* desc = "Typical resistor corner" *)
module res_typ();
    // rsil
    parameter real rsh_rsil = 7.0;
    parameter real dw_par_rsil = 0.01e-6;
    parameter real nsig_rsh_rsil = 0.0;
    parameter real nsig_w_rsil = 0.0;
    parameter real nsig_l_rsil = 0.0;
    // rhigh
    parameter real rsh_rhigh = 1360.0;
    parameter real dw_par_rhigh = -0.04e-6;
    parameter real nsig_rsh_rhigh = 0.0;
    parameter real nsig_w_rhigh = 0.0;
    parameter real nsig_l_rhigh = 0.0;
    // rppd
    parameter real rsh_rppd = 260.0;
    parameter real dw_par_rppd = 0.006e-6;
    parameter real nsig_rsh_rppd = 0.0;
    parameter real nsig_w_rppd = 0.0;
    parameter real nsig_l_rppd = 0.0;
    // parasitic
    parameter real res_rpara = 1.0;
endmodule

(* desc = "Best-case resistor corner" *)
module res_bcs();
    // rsil
    parameter real rsh_rsil = 6.02;
    parameter real dw_par_rsil = 0.04e-6;
    parameter real nsig_rsh_rsil = 0.0;
    parameter real nsig_w_rsil = 0.0;
    parameter real nsig_l_rsil = 0.0;
    // rhigh
    parameter real rsh_rhigh = 1020.0;
    parameter real dw_par_rhigh = 0.0;
    parameter real nsig_rsh_rhigh = 0.0;
    parameter real nsig_w_rhigh = 0.0;
    parameter real nsig_l_rhigh = 0.0;
    // rppd
    parameter real rsh_rppd = 234.0;
    parameter real dw_par_rppd = 0.036e-6;
    parameter real nsig_rsh_rppd = 0.0;
    parameter real nsig_w_rppd = 0.0;
    parameter real nsig_l_rppd = 0.0;
    // parasitic
    parameter real res_rpara = 1.0;
endmodule

(* desc = "Worst-case resistor corner" *)
module res_wcs();
    // rsil
    parameter real rsh_rsil = 7.98;
    parameter real dw_par_rsil = -0.02e-6;
    parameter real nsig_rsh_rsil = 0.0;
    parameter real nsig_w_rsil = 0.0;
    parameter real nsig_l_rsil = 0.0;
    // rhigh
    parameter real rsh_rhigh = 1700.0;
    parameter real dw_par_rhigh = -0.08e-6;
    parameter real nsig_rsh_rhigh = 0.0;
    parameter real nsig_w_rhigh = 0.0;
    parameter real nsig_l_rhigh = 0.0;
    // rppd
    parameter real rsh_rppd = 286.0;
    parameter real dw_par_rppd = -0.024e-6;
    parameter real nsig_rsh_rppd = 0.0;
    parameter real nsig_w_rppd = 0.0;
    parameter real nsig_l_rppd = 0.0;
    // parasitic
    parameter real res_rpara = 1.0;
endmodule

(* desc = "Statistical resistor corner" *)
module res_stat();
    parameter integer seed = 1;
    // rsil
    parameter real rsh_rsil = 7.0;
    parameter real dw_par_rsil = 0.01e-6;
    parameter real nsig_rsh_rsil = (0);
    parameter real nsig_w_rsil   = (0);
    parameter real nsig_l_rsil   = (0);
    // rhigh
    parameter real rsh_rhigh = 1360;
    parameter real dw_par_rhigh = -0.04e-6;
    parameter real nsig_rsh_rhigh = (0);
    parameter real nsig_w_rhigh   = (0);
    parameter real nsig_l_rhigh   = (0);
    // rppd
    parameter real rsh_rppd = 260.0;
    parameter real dw_par_rppd = 0.006e-6;
    parameter real nsig_rsh_rppd = (0);
    parameter real nsig_w_rppd   = (0);
    parameter real nsig_l_rppd   = (0);
    // parasitic
    parameter real res_rpara_nom = 1.0;
    parameter real res_rpara_sig = 0.067;
    parameter real res_rpara = (res_rpara_nom);
endmodule

(* desc = "Global-variation sigma parameters" *)
module res_stat_param();
  // rsil
  parameter real drsh_rsil = 4.67; // % of 1 Sigma
  parameter real dw_rsil = 0.01; // um of 1 Sigma
  parameter real dl_rsil = 0.01; // um of 1 Sigma
  // rhigh
  parameter real drsh_rhigh = 8.33; // % of 1 Sigma
  parameter real dl_rhigh = 0.015; // um of 1 Sigma
  parameter real dw_rhigh = 0.015; // um of 1 Sigma
  // rppd
  parameter real drsh_rppd = 3.3; // % of 1 Sigma
  parameter real dl_rppd = 0.01; // um of 1 Sigma
  parameter real dw_rppd = 0.01; // um of 1 Sigma
endmodule

(* desc = "Mismatch sigma parameters and random variables" *)
module res_mm();
  // rsil
  parameter real drsh_mm_rsil  = 1.7; // local %um of 1 Sigma
  parameter real dl_mm_rsil = 0.006; // local um of 1 Sigma
  parameter real dw_mm_rsil = 0.006; // local um of 1 Sigma
  parameter real nsmm_rsh_rsil = (0.0);
  parameter real nsmm_w_rsil   = (0.0);
  parameter real nsmm_l_rsil   = (0.0);
  // rhigh
  parameter real drsh_mm_rhigh = 5.0; // local %um of 1 Sigma
  parameter real dl_mm_rhigh = 0.009; // local um of 1 Sigma
  parameter real dw_mm_rhigh = 0.009; // local um of 1 Sigma
  parameter real nsmm_rsh_rhigh = (0.0);
  parameter real nsmm_w_rhigh   = (0.0);
  parameter real nsmm_l_rhigh   = (0.0);
  // rppd
  parameter real drsh_mm_rppd = 2.0; // local %um of 1 Sigma
  parameter real dl_mm_rppd = 0.006; // local um of 1 Sigma
  parameter real dw_mm_rppd = 0.006; // local um of 1 Sigma
  parameter real nsmm_rsh_rppd = (0.0);
  parameter real nsmm_w_rppd   = (0.0);
  parameter real nsmm_l_rppd   = (0.0);
endmodule
