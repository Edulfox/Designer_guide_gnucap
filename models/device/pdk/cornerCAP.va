//******************************************************************************
//
// Copyright 2026 IHP PDK Authors
//
// Licensed under the Apache License, Version 2.0 (the "License");
// you may not use this file except in compliance with the License.
// You may obtain a copy of the License at
//
//    https://www.apache.org/licenses/LICENSE-2.0
//
// Unless required by applicable law or agreed to in writing, software
// distributed under the License is distributed on an "AS IS" BASIS,
// WITHOUT WARRANTIES OR CONDITIONS OF ANY KIND, either express or implied.
// See the License for the specific language governing permissions and
// limitations under the License.
//
//******************************************************************************

//******************************************************************************
// Capacitor corner modules
//
// Adapted from `ngspice/models/cornerCAP.lib`
//
// Modifications:
// - Mismatch corners removed; mismatch device variants use paramset overloading
// - cap_carea converted to SI units (F/m^2)
//******************************************************************************

(* desc = "typical capacitor corner" *)
module cap_typ();
    parameter real cap_carea = 1.5E-3; // F/m^2
    parameter real cap_cpara = 1.0;
endmodule

(* desc = "best-case capacitor corner" *)
module cap_bcs();
    parameter real cap_carea = 0.9 * 1.5E-3; // F/m^2
    parameter real cap_cpara = 0.9;
endmodule

(* desc = "worst-case capacitor corner" *)
module cap_wcs();
    parameter real cap_carea = 1.1 * 1.5E-3; // F/m^2
    parameter real cap_cpara = 1.1;
endmodule

(* desc = "statistical capacitor corner" *)
module cap_typ_stat();
    parameter integer seed = 0;
    parameter real cap_carea_nom = 1.5E-3; // F/m^2
    parameter real cap_cpara_nom  = 1.0;
    parameter real cap_carea_sig = 0.033 * cap_carea_nom;
    parameter real cap_cpara_sig = 0.067 * cap_cpara_nom;
    parameter real cap_carea = (cap_carea_nom);
    parameter real cap_cpara = (cap_cpara_nom);
endmodule

(* desc = "capacitor mismatch parameters" *)
module cap_mm();
    parameter real cap_carea_mm = (1);
endmodule
