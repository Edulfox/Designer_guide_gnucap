//////////////////////////////////////////////////////////////////////////////
// Copyright 2026 IHP-Open-PDK Authors
//
// Licensed under the Apache License, Version 2.0 (the "License");
// you may not use this file except in compliance with the License.
// You may obtain a copy of the License at
//
//     https://www.apache.org/licenses/LICENSE-2.0
//
// Unless required by applicable law or agreed to in writing, software
// distributed under the License is distributed on an "AS IS" BASIS,
// WITHOUT WARRANTIES OR CONDITIONS OF ANY KIND, either express or implied.
// See the License for the specific language governing permissions and
// limitations under the License.
//////////////////////////////////////////////////////////////////////////////

`include "disciplines.vams"

// Junction diode from The Designer's Guide, Chapter 3, Listing 11.
module diode (a, c);
   parameter real is = 10f;
   parameter real tf = 0.0;
   parameter real cjo = 0.0;
   parameter real phi = 0.7;
   inout a, c;
   electrical a, c;
   branch (a, c) res, cap;
   real qd;
   analog begin
      I(res) <+ is*(limexp(V(res)/$vt) - 1.0);
      qd = tf*I(res) - 2.0*cjo*phi*sqrt(1.0 - V(cap)/phi);
      I(cap) <+ ddt(qd);
   end
endmodule
