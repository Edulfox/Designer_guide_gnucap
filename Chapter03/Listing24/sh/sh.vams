//////////////////////////////////////////////////////////////////////////////
// Copyright 2026 IHP-Open-PDK Authors
//
// Licensed under the Apache License, Version 2.0 (the "License");
// you may not use this file except in compliance with the License.
// You may obtain a copy of the License at
//
//     https://www.apache.org/licenses/LICENSE-2.0
//
// Unless required by applicable law or agreed to in writing, software
// distributed under the License is distributed on an "AS IS" BASIS,
// WITHOUT WARRANTIES OR CONDITIONS OF ANY KIND, either express or implied.
// See the License for the specific language governing permissions and
// limitations under the License.
//////////////////////////////////////////////////////////////////////////////

`include "disciplines.vams"

// Smoothed periodic self-clocked sample-and-hold from Chapter 3, Listing 24.
module sh (p, n, ps, ns);
   parameter real period = 1.0;
   parameter real toff = 0.0;
   parameter real td = 0.0;
   parameter real tt = period/100.0;
   input ps, ns;
   output p, n;
   electrical p, n, ps, ns;
   real save;
   analog begin
      @(timer(toff, period) or initial_step)
         save = V(ps,ns);
      V(p,n) <+ transition(save, td, tt);
   end
endmodule
