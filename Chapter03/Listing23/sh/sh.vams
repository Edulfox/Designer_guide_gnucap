//////////////////////////////////////////////////////////////////////////////
// Copyright 2026 IHP-Open-PDK Authors
//
// Licensed under the Apache License, Version 2.0 (the "License");
// you may not use this file except in compliance with the License.
// You may obtain a copy of the License at
//
//     https://www.apache.org/licenses/LICENSE-2.0
//
// Unless required by applicable law or agreed to in writing, software
// distributed under the License is distributed on an "AS IS" BASIS,
// WITHOUT WARRANTIES OR CONDITIONS OF ANY KIND, either express or implied.
// See the License for the specific language governing permissions and
// limitations under the License.
//////////////////////////////////////////////////////////////////////////////

`include "disciplines.vams"

// Ideal periodic self-clocked sample-and-hold from Chapter 3, Listing 23.
module sh (p, n, ps, ns);
   parameter real period = 1.0;
   parameter real toff = 0.0;
   output p, n;
   input ps, ns;
   electrical p, n, ps, ns;
   real save;
   analog begin
      @(timer(toff, period) or initial_step) begin
         save = V(ps,ns);
         $discontinuity(0);
      end
      V(p,n) <+ save;
   end
endmodule
