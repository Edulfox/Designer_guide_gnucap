//////////////////////////////////////////////////////////////////////////////
// Copyright 2026 IHP-Open-PDK Authors
//
// Licensed under the Apache License, Version 2.0 (the "License");
// you may not use this file except in compliance with the License.
// You may obtain a copy of the License at
//
//     https://www.apache.org/licenses/LICENSE-2.0
//
// Unless required by applicable law or agreed to in writing, software
// distributed under the License is distributed on an "AS IS" BASIS,
// WITHOUT WARRANTIES OR CONDITIONS OF ANY KIND, either express or implied.
// See the License for the specific language governing permissions and
// limitations under the License.
//////////////////////////////////////////////////////////////////////////////

`include "disciplines.vams"

// Explicit-branch shunt RLC with a Gnucap-compatible inductor formulation.
module shunt_rlc (p, n);
   parameter real r = 0.0;
   parameter real l = 0.0;
   parameter real c = 0.0;
   inout p, n;
   electrical p, n;
   branch (p,n) res, cap, ind;

   analog begin
      V(res) <+ r*I(res);
      I(cap) <+ c*ddt(V(cap));

      if (l == 0.0)
         V(ind) <+ 0.0;
      else
         I(ind) <+ idt(V(ind))/l;
   end
endmodule
