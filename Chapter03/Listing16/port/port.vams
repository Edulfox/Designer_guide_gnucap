//////////////////////////////////////////////////////////////////////////////
// Copyright 2026 IHP-Open-PDK Authors
//
// Licensed under the Apache License, Version 2.0 (the "License");
// you may not use this file except in compliance with the License.
// You may obtain a copy of the License at
//
//     https://www.apache.org/licenses/LICENSE-2.0
//
// Unless required by applicable law or agreed to in writing, software
// distributed under the License is distributed on an "AS IS" BASIS,
// WITHOUT WARRANTIES OR CONDITIONS OF ANY KIND, either express or implied.
// See the License for the specific language governing permissions and
// limitations under the License.
//////////////////////////////////////////////////////////////////////////////

`include "disciplines.vams"
`include "constants.vams"

// Resistive port using a Gnucap-compatible Norton-equivalent formulation.
module port (p, n);
   parameter real r = 50.0;
   parameter real dc = 0.0;
   parameter real mag = 0.0;
   inout p, n;
   electrical p, n;

   analog begin
      I(p,n) <+ V(p,n)/r - 2.0*dc/r;
      I(p,n) <+ ac_stim("ac", 2.0*mag/r);
      I(p,n) <+ white_noise(4.0*`P_K*$temperature/r, "thermal");
   end
endmodule
