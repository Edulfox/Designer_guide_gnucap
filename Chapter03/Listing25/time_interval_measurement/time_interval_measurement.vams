//////////////////////////////////////////////////////////////////////////////
// Copyright 2026 IHP-Open-PDK Authors
//
// Licensed under the Apache License, Version 2.0 (the "License");
// you may not use this file except in compliance with the License.
// You may obtain a copy of the License at
//
//     https://www.apache.org/licenses/LICENSE-2.0
//
// Unless required by applicable law or agreed to in writing, software
// distributed under the License is distributed on an "AS IS" BASIS,
// WITHOUT WARRANTIES OR CONDITIONS OF ANY KIND, either express or implied.
// See the License for the specific language governing permissions and
// limitations under the License.
//////////////////////////////////////////////////////////////////////////////

`include "disciplines.vams"

// Time-interval measurement based on Chapter 3, Listing 25.
// The book uses last_crossing(), which is not implemented in the supplied
// modelgen snapshot. Crossing times are therefore captured with $abstime at
// the cross events. The arming, accumulation, mean calculation, and final
// report remain the same.
module time_interval_measurement (start, stop);
   parameter real thresh = 0.5;
   parameter integer dir = 1;
   input start, stop;
   electrical start, stop;
   (*desc="count"*) integer count = 0;
   integer armed = 0;
   real t0 = 0.0;
   real t1 = 0.0;
   real sum = 0.0;
   (*desc="mean"*) real mean = 0.0;
   analog begin
      @(cross(V(start) - thresh, dir)) begin
         t0 = $abstime;
         armed = 1;
      end
      @(cross(V(stop) - thresh, dir)) begin
         t1 = $abstime;
         if (armed) begin
            armed = 0;
            count = count + 1;
            sum = sum + (t1 - t0);
            mean = sum/count;
         end
      end
      @(final_step) begin
         $strobe("time interval measurements = %d", count);
         if (count)
            $strobe("mean time interval (est) = %g", mean);
         else
            $strobe("Could not measure time interval.");
      end
   end
endmodule
