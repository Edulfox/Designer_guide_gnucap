//////////////////////////////////////////////////////////////////////////////
// Copyright 2026 IHP-Open-PDK Authors
//
// Licensed under the Apache License, Version 2.0 (the "License");
// you may not use this file except in compliance with the License.
// You may obtain a copy of the License at
//
//     https://www.apache.org/licenses/LICENSE-2.0
//
// Unless required by applicable law or agreed to in writing, software
// distributed under the License is distributed on an "AS IS" BASIS,
// WITHOUT WARRANTIES OR CONDITIONS OF ANY KIND, either express or implied.
// See the License for the specific language governing permissions and
// limitations under the License.
//////////////////////////////////////////////////////////////////////////////

`include "disciplines.vams"

// Ideal diode from The Designer's Guide, Chapter 3, Listing 21.
module diode (a, c);
   inout a, c;
   electrical a, c;
   analog begin
      @(cross(V(a,c) + I(a,c), 0))
         ;
      if ((V(a,c) + I(a,c)) > 0)
         V(a,c) <+ 0.0;
      else
         I(a,c) <+ 0.0;
   end
endmodule
